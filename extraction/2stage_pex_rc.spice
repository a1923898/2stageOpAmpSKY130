* NGSPICE file created from 2stage_final.ext - technology: sky130A

.subckt sky130_fd_pr__nfet_01v8_49BEQD a_50_n800# a_n108_n800# a_n50_n888# a_n210_n974#
X0 a_50_n800# a_n50_n888# a_n108_n800# a_n210_n974# sky130_fd_pr__nfet_01v8 ad=2.32 pd=16.58 as=2.32 ps=16.58 w=8 l=0.5
C0 a_n50_n888# a_50_n800# 0.102997f
C1 a_50_n800# a_n108_n800# 0.712574f
C2 a_n50_n888# a_n108_n800# 0.102997f
C3 a_50_n800# a_n210_n974# 0.882577f
C4 a_n108_n800# a_n210_n974# 0.882577f
C5 a_n50_n888# a_n210_n974# 0.466655f
.ends

.subckt sky130_fd_pr__pfet_01v8_XUL9ZV a_n200_n4597# w_n396_n4719# a_200_n4500# a_n258_n4500#
+ VSUBS
X0 a_200_n4500# a_n200_n4597# a_n258_n4500# w_n396_n4719# sky130_fd_pr__pfet_01v8 ad=13.05 pd=90.58 as=13.05 ps=90.58 w=45 l=2
C0 w_n396_n4719# a_200_n4500# 2.76811f
C1 w_n396_n4719# a_n258_n4500# 2.76811f
C2 a_200_n4500# a_n200_n4597# 1.40026f
C3 a_n258_n4500# a_n200_n4597# 1.40026f
C4 a_n258_n4500# a_200_n4500# 1.38266f
C5 w_n396_n4719# a_n200_n4597# 0.743433f
C6 a_200_n4500# VSUBS 2.63437f
C7 a_n258_n4500# VSUBS 2.63437f
C8 a_n200_n4597# VSUBS 0.688114f
C9 w_n396_n4719# VSUBS 27.2862f
.ends

.subckt sky130_fd_pr__nfet_01v8_96BL9R a_n50_n1588# a_n108_n1500# a_50_n1500# a_n210_n1674#
X0 a_50_n1500# a_n50_n1588# a_n108_n1500# a_n210_n1674# sky130_fd_pr__nfet_01v8 ad=4.35 pd=30.58 as=4.35 ps=30.58 w=15 l=0.5
C0 a_n50_n1588# a_50_n1500# 0.189722f
C1 a_50_n1500# a_n108_n1500# 1.33452f
C2 a_n50_n1588# a_n108_n1500# 0.189722f
C3 a_50_n1500# a_n210_n1674# 1.62366f
C4 a_n108_n1500# a_n210_n1674# 1.62366f
C5 a_n50_n1588# a_n210_n1674# 0.466655f
.ends

.subckt sky130_fd_pr__cap_mim_m3_1_4BH623 m3_n3186_n13840# c1_n3146_n13800# VSUBS
X0 c1_n3146_n13800# m3_n3186_n13840# sky130_fd_pr__cap_mim_m3_1 l=26.32 w=30
X1 c1_n3146_n13800# m3_n3186_n13840# sky130_fd_pr__cap_mim_m3_1 l=26.32 w=30
X2 c1_n3146_n13800# m3_n3186_n13840# sky130_fd_pr__cap_mim_m3_1 l=26.32 w=30
X3 c1_n3146_n13800# m3_n3186_n13840# sky130_fd_pr__cap_mim_m3_1 l=26.32 w=30
X4 c1_n3146_n13800# m3_n3186_n13840# sky130_fd_pr__cap_mim_m3_1 l=26.32 w=30
C0 m3_n3186_n13840# c1_n3146_n13800# 0.348296p
C1 c1_n3146_n13800# VSUBS 8.285669f
C2 m3_n3186_n13840# VSUBS 73.6006f
.ends

.subckt sky130_fd_pr__pfet_01v8_WHL9HY a_n258_n9000# a_n200_n9097# w_n396_n9219# a_200_n9000#
+ VSUBS
X0 a_200_n9000# a_n200_n9097# a_n258_n9000# w_n396_n9219# sky130_fd_pr__pfet_01v8 ad=26.1 pd=180.58 as=26.1 ps=180.58 w=90 l=2
C0 w_n396_n9219# a_200_n9000# 5.51198f
C1 w_n396_n9219# a_n258_n9000# 5.51198f
C2 a_200_n9000# a_n200_n9097# 2.79397f
C3 a_n258_n9000# a_n200_n9097# 2.79397f
C4 a_n258_n9000# a_200_n9000# 2.76478f
C5 w_n396_n9219# a_n200_n9097# 0.743433f
C6 a_200_n9000# VSUBS 5.25942f
C7 a_n258_n9000# VSUBS 5.25942f
C8 a_n200_n9097# VSUBS 0.688114f
C9 w_n396_n9219# VSUBS 53.004105f
.ends

.subckt sky130_fd_pr__nfet_01v8_DDF85Q a_n258_n3000# a_200_n3000# a_n360_n3174# a_n200_n3088#
X0 a_200_n3000# a_n200_n3088# a_n258_n3000# a_n360_n3174# sky130_fd_pr__nfet_01v8 ad=8.7 pd=60.58 as=8.7 ps=60.58 w=30 l=2
C0 a_n200_n3088# a_200_n3000# 0.935694f
C1 a_200_n3000# a_n258_n3000# 0.921951f
C2 a_n200_n3088# a_n258_n3000# 0.935694f
C3 a_200_n3000# a_n360_n3174# 3.61328f
C4 a_n258_n3000# a_n360_n3174# 3.61328f
C5 a_n200_n3088# a_n360_n3174# 1.40217f
.ends

.subckt sky130_fd_pr__res_xhigh_po_0p35_JYCGL6 a_n35_n1885# a_n35_1453# VSUBS
X0 a_n35_1453# a_n35_n1885# VSUBS sky130_fd_pr__res_xhigh_po_0p35 l=14.69
C0 a_n35_n1885# VSUBS 0.593894f
C1 a_n35_1453# VSUBS 0.593894f
.ends

.subckt x2stage_final Iref VDD VSS Vout Vin+ Vin-
Xsky130_fd_pr__nfet_01v8_49BEQD_0 VSS Vout Iref VSS sky130_fd_pr__nfet_01v8_49BEQD
Xsky130_fd_pr__pfet_01v8_XUL9ZV_0 m1_1247_24133# VDD Vout VDD VSS sky130_fd_pr__pfet_01v8_XUL9ZV
Xsky130_fd_pr__nfet_01v8_96BL9R_0 Iref m1_n750_n236# VSS VSS sky130_fd_pr__nfet_01v8_96BL9R
Xsky130_fd_pr__nfet_01v8_96BL9R_1 Iref Iref VSS VSS sky130_fd_pr__nfet_01v8_96BL9R
Xsky130_fd_pr__cap_mim_m3_1_4BH623_0 Vout m1_1564_11754# VSS sky130_fd_pr__cap_mim_m3_1_4BH623
Xsky130_fd_pr__pfet_01v8_WHL9HY_0 VDD m1_40_6116# VDD m1_1247_24133# VSS sky130_fd_pr__pfet_01v8_WHL9HY
Xsky130_fd_pr__nfet_01v8_DDF85Q_0 m1_40_6116# m1_n750_n236# VSS Vin- sky130_fd_pr__nfet_01v8_DDF85Q
Xsky130_fd_pr__res_xhigh_po_0p35_JYCGL6_0 m1_1247_24133# m1_1564_11754# VSS sky130_fd_pr__res_xhigh_po_0p35_JYCGL6
Xsky130_fd_pr__pfet_01v8_WHL9HY_1 m1_40_6116# m1_40_6116# VDD VDD VSS sky130_fd_pr__pfet_01v8_WHL9HY
Xsky130_fd_pr__nfet_01v8_DDF85Q_1 m1_n750_n236# m1_1247_24133# VSS Vin+ sky130_fd_pr__nfet_01v8_DDF85Q
X0 m1_1564_11754# Vout.t2 sky130_fd_pr__cap_mim_m3_1 l=0 w=0
X1 VSS Iref.t2 Vout VSS sky130_fd_pr__nfet_01v8 ad=2.32 pd=16.58 as=2.32 ps=16.58 w=0 l=0
X2 m1_1564_11754# Vout.t0 sky130_fd_pr__cap_mim_m3_1 l=0 w=0
X3 VDD m1_40_6116.t1 m1_40_6116.t0 VDD.t0 sky130_fd_pr__pfet_01v8 ad=26.1 pd=180.58 as=26.1 ps=180.58 w=0 l=0
X4 VSS Iref.t3 m1_n750_n236# VSS sky130_fd_pr__nfet_01v8 ad=4.35 pd=30.58 as=4.35 ps=30.58 w=0 l=0
X5 VSS Iref.t0 Iref.t1 VSS sky130_fd_pr__nfet_01v8 ad=4.35 pd=30.58 as=4.35 ps=30.58 w=0 l=0
X6 m1_1247_24133# Vin+.t0 m1_n750_n236# VSS sky130_fd_pr__nfet_01v8 ad=8.7 pd=60.58 as=8.7 ps=60.58 w=0 l=0
X7 m1_1564_11754# Vout.t1 sky130_fd_pr__cap_mim_m3_1 l=0 w=0
X8 m1_n750_n236# Vin-.t0 m1_40_6116.t0 VSS.t0 sky130_fd_pr__nfet_01v8 ad=8.7 pd=60.58 as=8.7 ps=60.58 w=0 l=0
X9 m1_1247_24133# m1_40_6116.t2 VDD VDD sky130_fd_pr__pfet_01v8 ad=26.1 pd=180.58 as=26.1 ps=180.58 w=0 l=0
R0 Iref.t3 Iref.t2 1484.45
R1 Iref.n0 Iref.t3 911.025
R2 Iref.n0 Iref.t0 910.826
R3 Iref.n1 Iref.t1 5.59187
R4 Iref.n1 Iref.n0 3.43774
R5 Iref.n2 Iref.n1 2.98068
R6 Iref Iref.n2 0.438
R7 Iref.n2 Iref 0.00942857
R8 Vout Vout.n1 4.92311
R9 Vout.n0 Vout.t1 0.0431997
R10 Vout.n1 Vout.n0 0.0408496
R11 Vout.n1 Vout.t0 0.00202404
R12 Vout.n0 Vout.t2 0.00167848
R13 VSS.n20 VSS.n18 20180.9
R14 VSS.n53 VSS.n20 20180.9
R15 VSS.n42 VSS.n21 18193.5
R16 VSS.n43 VSS.n42 18193.5
R17 VSS.n32 VSS.n31 10620.6
R18 VSS.n31 VSS.n26 9600.85
R19 VSS.n36 VSS.n35 9600.85
R20 VSS.n17 VSS.n4 6622.68
R21 VSS.n56 VSS.n2 6622.68
R22 VSS.n8 VSS.n7 6564.73
R23 VSS.n7 VSS.n4 5544.97
R24 VSS.n11 VSS.n2 5544.97
R25 VSS.n40 VSS.n26 2277.09
R26 VSS.n36 VSS.n24 2277.09
R27 VSS.n43 VSS.n18 1987.38
R28 VSS.n53 VSS.n21 1987.38
R29 VSS.n49 VSS.n21 1987.38
R30 VSS.n46 VSS.n43 1674.5
R31 VSS.n6 VSS.n3 1378.04
R32 VSS.n44 VSS.n22 1311.25
R33 VSS.n52 VSS.n22 1311.25
R34 VSS.n51 VSS.n23 1182.12
R35 VSS.n45 VSS.n23 1182.12
R36 VSS.n32 VSS.n29 1085.65
R37 VSS.n37 VSS.n26 1019.76
R38 VSS.n37 VSS.n36 1019.76
R39 VSS.n14 VSS.n4 1019.76
R40 VSS.n14 VSS.n2 1019.76
R41 VSS.n30 VSS.n25 1015.71
R42 VSS.n50 VSS.t0 742.332
R43 VSS.n33 VSS.n27 690.072
R44 VSS.n34 VSS.n33 690.072
R45 VSS.n39 VSS.n27 623.812
R46 VSS.n34 VSS.n28 623.812
R47 VSS.n17 VSS.n16 449.178
R48 VSS.n9 VSS.n5 426.541
R49 VSS.n10 VSS.n9 426.541
R50 VSS.n16 VSS.n5 360.283
R51 VSS.n10 VSS.n1 360.283
R52 VSS.n57 VSS.n56 293.067
R53 VSS.t0 VSS.n41 243.356
R54 VSS.n41 VSS.n25 240.904
R55 VSS.n40 VSS.n39 212.953
R56 VSS.n28 VSS.n24 212.953
R57 VSS.n54 VSS.n19 210.255
R58 VSS.n46 VSS.n45 206.3
R59 VSS.n33 VSS.n32 195
R60 VSS.n38 VSS.n37 195
R61 VSS.n37 VSS.n25 195
R62 VSS.n9 VSS.n8 195
R63 VSS.n15 VSS.n14 195
R64 VSS.n14 VSS.n13 195
R65 VSS.n12 VSS.n8 186.272
R66 VSS.n47 VSS.n19 177.153
R67 VSS.n48 VSS.t0 146.504
R68 VSS.n57 VSS.n1 142.809
R69 VSS.n55 VSS.n54 136.083
R70 VSS.n51 VSS.n50 133.632
R71 VSS.n45 VSS.n44 129.13
R72 VSS.n52 VSS.n51 129.13
R73 VSS.n12 VSS.n11 107.597
R74 VSS.n47 VSS.n46 97.5005
R75 VSS.n13 VSS.n6 90.1396
R76 VSS.n55 VSS.n3 74.1716
R77 VSS.n44 VSS.n18 73.1255
R78 VSS.n54 VSS.n18 73.1255
R79 VSS.n53 VSS.n52 73.1255
R80 VSS.n54 VSS.n53 73.1255
R81 VSS.n49 VSS.n48 73.1255
R82 VSS.n50 VSS.n49 68.1994
R83 VSS.n39 VSS.n38 66.2593
R84 VSS.n38 VSS.n28 66.2593
R85 VSS.n16 VSS.n15 66.2593
R86 VSS.n15 VSS.n1 66.2593
R87 VSS.n41 VSS.n24 65.0005
R88 VSS.n41 VSS.n40 65.0005
R89 VSS.n48 VSS.n47 33.1016
R90 VSS.n62 VSS.n61 26.3399
R91 VSS.n7 VSS.n5 22.5005
R92 VSS.n7 VSS.n6 22.5005
R93 VSS.n11 VSS.n10 22.5005
R94 VSS.n56 VSS.n55 18.8715
R95 VSS.n55 VSS.n17 18.8715
R96 VSS.n35 VSS.n34 12.7179
R97 VSS.n31 VSS.n27 12.7179
R98 VSS.n31 VSS.n30 12.7179
R99 VSS.n35 VSS.n29 11.4047
R100 VSS.n42 VSS.n23 6.42907
R101 VSS.n42 VSS.n19 6.42907
R102 VSS.n22 VSS.n20 6.42907
R103 VSS.n20 VSS.n3 6.42907
R104 VSS.n13 VSS.n12 3.19707
R105 VSS.n30 VSS.n29 1.30099
R106 VSS.n58 VSS.n57 1.03383
R107 VSS.n0 VSS 0.998625
R108 VSS.n63 VSS 0.937375
R109 VSS.n60 VSS 0.76425
R110 VSS.n0 VSS 0.726148
R111 VSS.n60 VSS 0.687375
R112 VSS VSS.n64 0.584746
R113 VSS VSS.n59 0.57925
R114 VSS.n59 VSS 0.335038
R115 VSS.n60 VSS 0.299792
R116 VSS.n64 VSS.n63 0.26425
R117 VSS.n64 VSS 0.2505
R118 VSS.n63 VSS 0.224356
R119 VSS.n64 VSS 0.122155
R120 VSS.n58 VSS.n0 0.121887
R121 VSS.n59 VSS.n58 0.121526
R122 VSS.n63 VSS.n62 0.101729
R123 VSS.n62 VSS.n60 0.00919627
R124 VDD.n27 VDD.n18 33501.2
R125 VDD.n27 VDD.n19 33501.2
R126 VDD.n17 VDD.n15 32290.6
R127 VDD.n22 VDD.n15 32290.6
R128 VDD.n11 VDD.n3 17618.8
R129 VDD.n7 VDD.n4 17618.8
R130 VDD.n11 VDD.n4 17618.8
R131 VDD.n13 VDD.n12 8104.85
R132 VDD.n28 VDD.n16 5891.54
R133 VDD.n7 VDD.n6 4260.61
R134 VDD.n29 VDD.n14 4174.73
R135 VDD.n16 VDD.t0 4132.31
R136 VDD.n26 VDD.n25 3573.46
R137 VDD.n26 VDD.n20 3573.46
R138 VDD.n12 VDD.n2 3531.31
R139 VDD.n21 VDD.n0 3444.33
R140 VDD.n24 VDD.n21 3444.33
R141 VDD.n30 VDD.n29 2804.6
R142 VDD.n12 VDD.n11 2088.66
R143 VDD.n8 VDD.n5 1879.34
R144 VDD.n10 VDD.n5 1879.34
R145 VDD.n9 VDD.n8 1879.34
R146 VDD.n10 VDD.n9 1879.34
R147 VDD.n18 VDD.n17 1210.59
R148 VDD.n17 VDD.n1 1210.59
R149 VDD.n22 VDD.n19 1210.59
R150 VDD.n23 VDD.n22 1020
R151 VDD.n29 VDD.n28 800.88
R152 VDD.n18 VDD.n14 243.593
R153 VDD.n14 VDD.n13 220.468
R154 VDD.n24 VDD.n23 139.633
R155 VDD.n25 VDD.n24 129.13
R156 VDD.n20 VDD.n0 129.13
R157 VDD.n31 VDD.n0 129.13
R158 VDD.n23 VDD.n16 30.8338
R159 VDD.n11 VDD.n10 23.1255
R160 VDD.n8 VDD.n7 23.1255
R161 VDD.n25 VDD.n19 23.1255
R162 VDD.n19 VDD.n16 23.1255
R163 VDD.n20 VDD.n18 23.1255
R164 VDD.n13 VDD.n1 23.1255
R165 VDD.n30 VDD.n1 20.8816
R166 VDD.n32 VDD.n31 4.1789
R167 VDD.n31 VDD.n30 2.22884
R168 VDD.n9 VDD.n4 1.37087
R169 VDD.n4 VDD.n2 1.37087
R170 VDD.n5 VDD.n3 1.37087
R171 VDD.n6 VDD.n3 1.0399
R172 VDD.n21 VDD.n15 0.693384
R173 VDD.n28 VDD.n15 0.693384
R174 VDD.n27 VDD.n26 0.693384
R175 VDD.n28 VDD.n27 0.693384
R176 VDD VDD.n32 0.61925
R177 VDD.n6 VDD.n2 0.332385
R178 VDD.n32 VDD 0.058625
R179 m1_40_6116.n0 m1_40_6116.t2 1126.3
R180 m1_40_6116.n0 m1_40_6116.t1 112.695
R181 m1_40_6116.n1 m1_40_6116.n0 49.8055
R182 m1_40_6116.n1 m1_40_6116.t0 0.366835
R183 Vin- Vin-.t0 128.519
R184 Vin+.n0 Vin+.t0 401.841
R185 Vin+.n0 Vin+ 0.0705
R186 Vin+ Vin+.n0 0.0555
C0 m1_1564_11754# Vout 5.346737f
C1 m1_n750_n236# Vin- 0.171474f
C2 m1_1247_24133# VDD 1.486329f
C3 Vin+ m1_n750_n236# 0.171784f
C4 m1_1564_11754# Vin- 0.107952f
C5 Vin+ m1_1564_11754# 0.218208f
C6 m1_1247_24133# m1_1564_11754# 0.871057f
C7 Vout Vin- 0.172782f
C8 Vin+ Vout 0.463396f
C9 m1_1247_24133# Vout 1.534146f
C10 Iref Vout 0.122044f
C11 m1_1564_11754# VDD 1.008498f
C12 Vout VDD 0.920519f
C13 m1_40_6116.t0 VSS 0.179066f
C14 m1_40_6116.t2 VSS 4.35735f
C15 m1_40_6116.t1 VSS 7.75104f
C16 m1_40_6116.n0 VSS 5.29086f
C17 m1_40_6116.n1 VSS 1.42168f
C18 VDD.n2 VSS 1.77577f
C19 VDD.n7 VSS 1.20649f
C20 VDD.n8 VSS 0.100392f
C21 VDD.n10 VSS 0.100392f
C22 VDD.n11 VSS 0.521141f
C23 VDD.n12 VSS 3.96311f
C24 VDD.n13 VSS 5.36691f
C25 VDD.n14 VSS 3.16571f
C26 VDD.n15 VSS 0.182827f
C27 VDD.t0 VSS -2.74635f
C28 VDD.n16 VSS 6.77357f
C29 VDD.n18 VSS 0.543784f
C30 VDD.n21 VSS 0.182827f
C31 VDD.n26 VSS 0.189706f
C32 VDD.n27 VSS 0.189706f
C33 VDD.n28 VSS 4.52237f
C34 VDD.n29 VSS 3.84024f
C35 VDD.n31 VSS 0.464268f
C36 VDD.n32 VSS 0.608637f
C37 Vout.t2 VSS 18.749302f
C38 Vout.t1 VSS 0.244899p
C39 Vout.n0 VSS 58.086002f
C40 Vout.t0 VSS -0.354001f
C41 Vout.n1 VSS 37.705f
C42 m1_1247_24133# VSS 10.599829f
C43 Vin+ VSS 1.599442f
C44 Vin- VSS 1.598985f
C45 VDD VSS 0.17486p
C46 m1_1564_11754# VSS 10.028399f
C47 Iref VSS 3.409014f
C48 m1_n750_n236# VSS 8.267036f
C49 Vout VSS 73.64687f
.ends
